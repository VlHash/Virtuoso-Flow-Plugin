;; =====================================================================
;; vfp_context.il — design context extraction
;; ---------------------------------------------------------------------
;; STUB (Milestone 3). Extracts current lib/cell/view, instances,
;; parameters, nets and ports into the design-context JSON, and exports
;; it to VFP Tunnel. vfpGetCurrentCellView lives in vfp_utils.il.
;; =====================================================================

defun( vfpExtractInstances (cv)      vfpNotImplemented("vfpExtractInstances") )
defun( vfpExtractNets (cv)           vfpNotImplemented("vfpExtractNets") )
defun( vfpExtractPorts (cv)          vfpNotImplemented("vfpExtractPorts") )
defun( vfpExtractDesignContext ()    vfpNotImplemented("vfpExtractDesignContext") )
defun( vfpExportDesignContext ()     vfpNotImplemented("vfpExportDesignContext") )
