;; =====================================================================
;; vfp_ade.il — minimal ADE interaction
;; ---------------------------------------------------------------------
;; STUB (Milestone 7). If ADE automation proves unstable, VFP Tunnel
;; may ingest result files first and direct ADE triggering can follow.
;; =====================================================================

defun( vfpGetAdeContext ()       vfpNotImplemented("vfpGetAdeContext") )
defun( vfpListAdeTests ()        vfpNotImplemented("vfpListAdeTests") )
defun( vfpGetActiveAdeTest ()    vfpNotImplemented("vfpGetActiveAdeTest") )
defun( vfpRunAdeTest (testName)  vfpNotImplemented("vfpRunAdeTest") )
