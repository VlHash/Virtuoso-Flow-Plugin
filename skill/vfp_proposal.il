;; =====================================================================
;; vfp_proposal.il — receive, display, and handle proposals
;; ---------------------------------------------------------------------
;; STUB (Milestone 4). Proposal states:
;;   pending -> approved -> applied
;;           -> rejected
;;           -> failed -> rolled_back
;; =====================================================================

defun( vfpFetchPendingProposals ()      vfpNotImplemented("vfpFetchPendingProposals") )
defun( vfpShowProposal (proposal)       vfpNotImplemented("vfpShowProposal") )
defun( vfpApproveProposal (proposalId)  vfpNotImplemented("vfpApproveProposal") )
defun( vfpRejectProposal (proposalId)   vfpNotImplemented("vfpRejectProposal") )
defun( vfpApplyProposal (proposalId)    vfpNotImplemented("vfpApplyProposal") )
